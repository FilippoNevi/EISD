`include "disciplines.vams"
`timescale 1us / 1us

module circuit(vp, vn, rp, rn);
	// PARAMETERS
	parameter real is=10f from (0:inf);		// saturation current (A)
	parameter real tf=0 from [0:inf);		// forward transit time (s)
	parameter real cjo=0 from [0:inf);		// zero-bias junction capacitance (F)
	parameter real phi=0.7 exclude 0;		// built-in junction potential (V)
	parameter real r=100.0;					// resistor
	// PORTS
	inout vp, n, rp;
	// NODES
	electrical vp, n, rp;
	// BRANCHES
	branch (n, vp) V1;
	branch (vp, rp) D1;
	branch (rp, n) R1;
	// VARIABLE
	real qd;
	// GROUND NODE
	ground n;
	analog begin
		// Diode
		//V(D1) <+ $ln(I(D1)/is)*$vt;
		// Resistor
		//V(R1) <+ I(R1)*r;

		V(V1) <+ $ln(I(D1)/is)*$vt + I(R1)*r;
	end
endmodule
