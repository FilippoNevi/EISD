// DC voltage source
//
// Version 1a, 1 June 04
//
// Ken Kundert
//
// Downloaded from The Designer's Guide Community (www.designers-guide.org).
// Post any questions on www.designers-guide.org/Forum.
// Taken from "The Designer's Guide to Verilog-AMS" by Kundert & Zinke.
// Chapter 3, Listing 5.

`timescale 1us / 1us

`include "disciplines.vams"

module vsrc (p, n, dc);

    // PARAMETERS -----------------------

    // PORTS ---------------------------
    input [9:0] dc;
    output p, n;

    //ground n;

    // NODES ---------------------------
    electrical p, n;

    real vin;

    // BEHAVIOR ------------------------
    analog begin

        //@(cross(dc-0.5))

        if (dc > 0.5)
            vin = 3.0;
        else
            vin = 0.0;

        V(p, n) <+ transition(vin, 0, 50u, 50u);

    end
endmodule
